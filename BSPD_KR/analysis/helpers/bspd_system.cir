* BSPD_KR full-chain sim: implausibility timer, latch and power cycle (schematic v06)
* Run: ngspice -b bspd_system.cir
.param TRAMP=5m
* GLV 12V: on at t=0, power-cycled 5.0-5.2 s
VGLV glv 0 PWL(0 0 {TRAMP} 12 5.0 12 5.005 0 5.2 0 {5.2+TRAMP} 12)
* sensors: implausibility A = 300 ms at t=1.0 (must NOT trip), B = 1 s at t=2.0 (must trip), clears at 3.0
VCUR cur 0 PWL(0 2.5 1.0 2.5 1.001 2.9 1.3 2.9 1.301 2.5 2.0 2.5 2.001 2.9 3.0 2.9 3.001 2.5)
VBF  bf  0 PWL(0 0.6 1.0 0.6 1.001 3.5 1.3 3.5 1.301 0.6 2.0 0.6 2.001 3.5 3.0 3.5 3.001 0.6)
VBR  br  0 PWL(0 0.6 1.0 0.6 1.001 3.5 1.3 3.5 1.301 0.6 2.0 0.6 2.001 3.5 3.0 3.5 3.001 0.6)
.include bspd_core.inc
.control
tran 100u 6 0 200u uic
meas tran relay_on_after_poweron WHEN v(sdc)=0.5 RISE=1
meas tran sdc_during_300ms_fault FIND v(sdc) AT=1.29
meas tran t500_peak_300ms_fault MAX v(t500) FROM=1.0 TO=1.4
meas tran sdc_before_trip FIND v(sdc) AT=2.25
meas tran trip_time WHEN v(sdc)=0.5 FALL=1
meas tran sdc_fault_still_on FIND v(sdc) AT=2.9
meas tran sdc_after_fault_cleared FIND v(sdc) AT=3.5
meas tran sdc_2s_after_clear FIND v(sdc) AT=4.9
meas tran relay_on_after_powercycle WHEN v(sdc)=0.5 RISE=2
meas tran por_peak_at_poweron MAX v(por) FROM=0 TO=0.2
meas tran por_time_above_vtl WHEN v(por)=2.5 FALL=1
meas tran fault_n_min MIN v(fault) FROM=0.3 TO=4.9
quit
.endc
.end
